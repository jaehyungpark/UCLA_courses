// Design: ee115c/NMOS_IV
simulator lang=spectre
global 0
parameters VDS=500m VGS=0 VSB=500m
include "/usr/public.2/ee115c/cadence-labs/gpdk090_v3.4/models/spectre/gpdk090.scs" section=NN

// ee115c/NMOS_IV/schematic
NM0 (net8 net5 net9 net9) gpdk090_nmos1v w=(240n) l=100n m=(1)*(1)
V4 (net3 net4) vsource dc=0 type=dc
V3 (net3 net8) vsource dc=0 type=dc
V2 (net3 net9) vsource dc=VDS type=dc
V1 (net3 net6) vsource dc=VGS type=dc
V0 (net5 net9) vsource dc=VGS type=dc
PM0 (net9 net6 net4 net4) gpdk090_pmos1v w=(480n) l=100n m=(1)*(1)
simulatorOptions options temp=27
dc dc param=VDS start=0 stop=1 step=0.05
save V3:p V4:p
